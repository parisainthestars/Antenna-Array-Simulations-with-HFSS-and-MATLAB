# Ansys Electronics Desktop project, version 2024.2
materials:
  vacuum: permittivity=1
  pec: conductivity=1e+30

design HFSSDesign1 (HFSS, HFSS Modal Network, model units mm)
variables:
  dl = 55mm
  gl = 0.275mm
  dr = 0.1154mm
geometry:
  Dipole [pec] = cylinder(axis=Z, base_centre=(0mm, 0mm, -dl/2), radius=dr, height=dl)
  Port [vacuum] = cylinder(axis=Z, base_centre=(0mm, 0mm, -gl/2), radius=dr, height=gl)
  Port_1 = Port.copy()
  Dipole.subtract(Port_1)
  Port_Section1 = Port.section(plane=YZ)
  RadiatingSurface [vacuum] = region(absolute_offset=38.461538mm on all sides)
  Dipole_1..Dipole_7 [pec] = Dipole.duplicate_along_line(step=(0mm, 57.6524mm, 0mm), total=8)
  Port_2..Port_8 [vacuum] = Port.duplicate_along_line(step=(0mm, 57.6524mm, 0mm), total=8)
  Port_2_Section1 = Port_2.section(plane=YZ)
  Port_3_Section1 = Port_3.section(plane=YZ)
  Port_4_Section1 = Port_4.section(plane=YZ)
  Port_5_Section1 = Port_5.section(plane=YZ)
  Port_6_Section1 = Port_6.section(plane=YZ)
  Port_7_Section1 = Port_7.section(plane=YZ)
  Port_8_Section1 = Port_8.section(plane=YZ)
boundaries and excitations:
  Open1: Radiation Objects=RadiatingSurface
  1: Lumped Port Objects=Port_Section1 LumpedPortType=Modal Modes{Mode1{IntLine{(0, 0, -0.1375) -> (0, 0, 0.1375)} CharImp=Zpi RenormImp=73ohm}} Impedance=50ohm
  2: Lumped Port Objects=Port_2_Section1 LumpedPortType=Modal Modes{Mode1{IntLine{(0, 57.6524, -0.1375) -> (0, 57.6524, 0.1375)} CharImp=Zpi RenormImp=50ohm}} Impedance=50ohm
  3: Lumped Port Objects=Port_3_Section1 LumpedPortType=Modal Modes{Mode1{IntLine{(0, 115.3048, -0.1375) -> (0, 115.3048, 0.1375)} CharImp=Zpi RenormImp=50ohm}} Impedance=50ohm
  4: Lumped Port Objects=Port_4_Section1 LumpedPortType=Modal Modes{Mode1{IntLine{(0, 172.9572, -0.1375) -> (0, 172.9572, 0.1375)} CharImp=Zpi RenormImp=50ohm}} Impedance=50ohm
  5: Lumped Port Objects=Port_5_Section1 LumpedPortType=Modal Modes{Mode1{IntLine{(0, 230.6096, -0.1375) -> (0, 230.6096, 0.1375)} CharImp=Zpi RenormImp=50ohm}} Impedance=50ohm
  6: Lumped Port Objects=Port_6_Section1 LumpedPortType=Modal Modes{Mode1{IntLine{(0, 288.262, -0.1375) -> (0, 288.262, 0.1375)} CharImp=Zpi RenormImp=50ohm}} Impedance=50ohm
  7: Lumped Port Objects=Port_7_Section1 LumpedPortType=Modal Modes{Mode1{IntLine{(0, 345.9144, -0.1375) -> (0, 345.9144, 0.1375)} CharImp=Zpi RenormImp=50ohm}} Impedance=50ohm
  8: Lumped Port Objects=Port_8_Section1 LumpedPortType=Modal Modes{Mode1{IntLine{(0, 403.5668, -0.1375) -> (0, 403.5668, 0.1375)} CharImp=Zpi RenormImp=50ohm}} Impedance=50ohm
mesh:
  initial mesh: GlobalSurfApproximation{CurvedSurfaceApproxChoice=UseSlider SliderMeshSettings=2}
setups:
  Setup1: HfssDriven Frequency=2.6GHz MaxDeltaS=0.02 MaximumPasses=6 MinimumPasses=1 MinimumConvergedPasses=1 PercentRefinement=30 BasisOrder=1 PortAccuracy=2 DrivenSolverType="Direct Solver"
    sweep Sweep: 1GHz to 5GHz, 401 points; Type=Interpolating InterpTolerance=0.5 InterpMaxSolns=250 InterpUsePortImped=false PassivityErrorTolerance=0.0001
source amplitudes:
  1:1, 2:1, 3:1, 4:1, 5:1, 6:1, 7:1, 8:1: 1W 0deg
radiation setups:
  3D: Infinite Sphere Theta=90deg..90deg step 2deg Phi=0deg..360deg step 2deg
  Elevation: Infinite Sphere Theta=-180deg..180deg step 1deg Phi=0deg..90deg step 90deg
  Azimuth: Infinite Sphere Theta=90deg..90deg step 0deg Phi=-180deg..180deg step 1deg
  Antenna Parameter Overlay1: Antenna Overlay  SetupID=1 Solution=23 IntrinsicVariation="Freq=2.6GHz" UseNominalDesign Calculations="Max U,Peak Directivity,Peak Gain,Radiated Power,Radiation Efficiency,Front To Back Ratio,Total Efficiency,System Efficiency"
reports:
  S Parameter Plot 1: dB(S(1,1)) vs Freq on Setup1 : Sweep; markers m1 at 2.58GHz, m2 at 2.57GHz, MY1 at y=-9.83133
  Gain Plot 1: GainTotal vs Phi on Setup1 : LastAdaptive, 3D [Theta=90deg Freq=2.6GHz]
  Gain Plot 2: GainTotal vs Phi, Theta on Setup1 : LastAdaptive, 3D [Freq=2.6GHz]
  Antenna Params Plot 1: PeakDirectivity vs Freq on Setup1 : LastAdaptive; markers m1 at 2.6GHz
  Antenna Params Plot 2: BeamArea vs Freq on Setup1 : LastAdaptive
  Antenna Params Plot 3: mag(ArrayFactor) vs Freq on Setup1 : LastAdaptive
  Antenna Params Plot 4: RadiatedPower vs Freq on Setup1 : LastAdaptive
  S Parameter Plot 2: dB(S(1,1)) vs Freq on Setup1 : Sweep [dr=0.05mm,0.1mm,0.1154mm,0.15mm,0.2mm]
  Directivity Plot 1: DirTotal vs Theta on Setup1 : LastAdaptive, 3D [Phi=all Freq=2.6GHz]; markers m1 at 90deg, m2 at 90deg
